// SPDX-FileCopyrightText: APM contributors
// SPDX-License-Identifier: Apache-2.0
//
// APM Spectre model-only compatibility
// EXPERIMENTAL / UNVERIFIED
//
// Static structural checks only; no Spectre parse or numerical validation.
// The generated TT card selects Spectre's native PSP103 compact model.
// This wrapper supports APM benchmark variation only. IHP-native Spectre
// Monte Carlo is explicitly not claimed. Include the APM variation section.

simulator lang=spice
.include "sg13g2_lv_psp103_tt.sp"
simulator lang=spectre

subckt apm130_nmos (d g s b)
parameters w=1u l=130n
parameters apm__match_size=(w*l)/(1u*260n)
parameters apm__vth_a=1.00000006466816 apm__vth_b=-1.03470525986893e-7
parameters apm__drive_a=0.994763943689773 apm__drive_b=-0.00520932699352531
parameters apm__vth_intent=0.012*apm_bench_n_vth_process_z+0.008*apm__mos_vth_local_z/sqrt(apm__match_size)
parameters apm__drive_intent=(1+0.04*apm_bench_n_drive_process_z)*(1+0.025*apm__mos_drive_local_z/sqrt(apm__match_size))-1
parameters apm__vth_raw=2*apm__vth_intent/(apm__vth_a+sqrt(apm__vth_a*apm__vth_a+4*apm__vth_b*apm__vth_intent))
parameters apm__drive_raw=1+2*apm__drive_intent/(apm__drive_a+sqrt(apm__drive_a*apm__drive_a+4*apm__drive_b*apm__drive_intent))
Mapm130_core (d g s b) sg13g2_lv_nmos_psp w=w l=l nf=1 as=w*340n ad=w*340n ps=2*(w+340n) pd=2*(w+340n) ngcon=2 delvto=apm__vth_raw factuo=apm__drive_raw
ends apm130_nmos

subckt apm130_pmos (d g s b)
parameters w=1u l=130n
parameters apm__match_size=(w*l)/(1u*260n)
parameters apm__vth_a=1.00494572012777 apm__vth_b=0.000973039878089773
parameters apm__drive_a=0.986532014888923 apm__drive_b=-0.0132914599558503
parameters apm__vth_intent=0.012*apm_bench_p_vth_process_z+0.008*apm__mos_vth_local_z/sqrt(apm__match_size)
parameters apm__drive_intent=(1+0.04*apm_bench_p_drive_process_z)*(1+0.025*apm__mos_drive_local_z/sqrt(apm__match_size))-1
parameters apm__vth_raw=2*apm__vth_intent/(apm__vth_a+sqrt(apm__vth_a*apm__vth_a+4*apm__vth_b*apm__vth_intent))
parameters apm__drive_raw=1+2*apm__drive_intent/(apm__drive_a+sqrt(apm__drive_a*apm__drive_a+4*apm__drive_b*apm__drive_intent))
Mapm130_core (d g s b) sg13g2_lv_pmos_psp w=w l=l nf=1 as=w*340n ad=w*340n ps=2*(w+340n) pd=2*(w+340n) ngcon=2 delvto=apm__vth_raw factuo=apm__drive_raw
ends apm130_pmos
