// SPDX-FileCopyrightText: APM contributors
// SPDX-License-Identifier: Apache-2.0
//
// APM v2 model-only Spectre binding for apm130/hv
// EXPERIMENTAL / UNVERIFIED
// Generated by tools/generate_spectre_v2.py.
// Static structure only: not parsed or simulated by Cadence Spectre.
// Include variation/spectre/benchmark_variation.scs with one section.

simulator lang=spice
.include "../../../spectre/sg13g2_hv_psp103_tt.sp"
simulator lang=spectre

subckt apm130_hv_nmos (d g s b)
parameters w=9.9999999999999995e-07 l=4.4999999999999998e-07
parameters apm__match_size=(w*l)/(9.9999999999999995e-07*8.9999999999999996e-07)
parameters apm__vth_adapter_a=1.005144894598917 apm__vth_adapter_b=0.00054754811539308096
parameters apm__drive_adapter_a=0.99538075398510695 apm__drive_adapter_b=-0.0045985332830548401
parameters apm__vth_intent=0.012*apm_bench_apm130_n_vth_global_z+0.0080000000000000002*apm__mos_vth_local_z/sqrt(apm__match_size)
parameters apm__drive_intent=(1+0.029999999999999999*apm_bench_apm130_n_drive_global_z)*(1+0.025000000000000001*apm__mos_drive_local_z/sqrt(apm__match_size))-1
parameters apm__vth_raw=2*apm__vth_intent/(apm__vth_adapter_a+sqrt(apm__vth_adapter_a*apm__vth_adapter_a+4*apm__vth_adapter_b*apm__vth_intent))
parameters apm__drive_raw=1+2*apm__drive_intent/(apm__drive_adapter_a+sqrt(apm__drive_adapter_a*apm__drive_adapter_a+4*apm__drive_adapter_b*apm__drive_intent))
Mapm__core (d g s b) sg13g2_hv_nmos_psp w=w l=l nf=1 as=w*340n ad=w*340n ps=2*(w+340n) pd=2*(w+340n) ngcon=2 delvto=apm__vth_raw factuo=apm__drive_raw
ends apm130_hv_nmos

subckt apm130_hv_pmos (d g s b)
parameters w=9.9999999999999995e-07 l=3.9999999999999998e-07
parameters apm__match_size=(w*l)/(9.9999999999999995e-07*7.9999999999999996e-07)
parameters apm__vth_adapter_a=1.0136457128645631 apm__vth_adapter_b=0.0015715661151944501
parameters apm__drive_adapter_a=0.99239660007929398 apm__drive_adapter_b=-0.0075472588456598601
parameters apm__vth_intent=0.012*apm_bench_apm130_p_vth_global_z+0.0080000000000000002*apm__mos_vth_local_z/sqrt(apm__match_size)
parameters apm__drive_intent=(1+0.029999999999999999*apm_bench_apm130_p_drive_global_z)*(1+0.025000000000000001*apm__mos_drive_local_z/sqrt(apm__match_size))-1
parameters apm__vth_raw=2*apm__vth_intent/(apm__vth_adapter_a+sqrt(apm__vth_adapter_a*apm__vth_adapter_a+4*apm__vth_adapter_b*apm__vth_intent))
parameters apm__drive_raw=1+2*apm__drive_intent/(apm__drive_adapter_a+sqrt(apm__drive_adapter_a*apm__drive_adapter_a+4*apm__drive_adapter_b*apm__drive_intent))
Mapm__core (d g s b) sg13g2_hv_pmos_psp w=w l=l nf=1 as=w*340n ad=w*340n ps=2*(w+340n) pd=2*(w+340n) ngcon=2 delvto=apm__vth_raw factuo=apm__drive_raw
ends apm130_hv_pmos
