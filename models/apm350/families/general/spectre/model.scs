// SPDX-FileCopyrightText: APM contributors
// SPDX-License-Identifier: Apache-2.0
//
// APM v2 model-only Spectre binding for apm350/general
// EXPERIMENTAL / UNVERIFIED
// Generated by tools/generate_spectre_v2.py.
// Static structure only: not parsed or simulated by Cadence Spectre.
// Include variation/spectre/benchmark_variation.scs with one section.

simulator lang=spice
.include "../../../ngspice/apm350_models.inc"
simulator lang=spectre

subckt apm350_general_nmos (d g s b)
parameters w=9.9999999999999995e-07 l=3.9999999999999998e-07
parameters apm__match_size=(w*l)/(9.9999999999999995e-07*7.9999999999999996e-07)
parameters apm__vth_adapter_a=1.0065193222702229 apm__vth_adapter_b=0.0038243352186580599
parameters apm__drive_adapter_a=0.97907617193954699 apm__drive_adapter_b=-0.035149324945195397
parameters apm__vth_intent=0.012*apm_bench_apm350_n_vth_global_z+0.0080000000000000002*apm__mos_vth_local_z/sqrt(apm__match_size)
parameters apm__drive_intent=(1+0.029999999999999999*apm_bench_apm350_n_drive_global_z)*(1+0.025000000000000001*apm__mos_drive_local_z/sqrt(apm__match_size))-1
parameters apm__vth_raw=2*apm__vth_intent/(apm__vth_adapter_a+sqrt(apm__vth_adapter_a*apm__vth_adapter_a+4*apm__vth_adapter_b*apm__vth_intent))
parameters apm__drive_raw=1+2*apm__drive_intent/(apm__drive_adapter_a+sqrt(apm__drive_adapter_a*apm__drive_adapter_a+4*apm__drive_adapter_b*apm__drive_intent))
Mapm__core (d g s b) apm350_ncore w=w l=l ad=w*400n as=w*400n pd=2*w+800n ps=2*w+800n delvto=apm__vth_raw mulu0=apm__drive_raw
ends apm350_general_nmos

subckt apm350_general_pmos (d g s b)
parameters w=9.9999999999999995e-07 l=3.9999999999999998e-07
parameters apm__match_size=(w*l)/(9.9999999999999995e-07*7.9999999999999996e-07)
parameters apm__vth_adapter_a=-1.0080212852524091 apm__vth_adapter_b=0.0044835939282655999
parameters apm__drive_adapter_a=1.009967450317669 apm__drive_adapter_b=-0.0114111639956943
parameters apm__vth_intent=0.012*apm_bench_apm350_p_vth_global_z+0.0080000000000000002*apm__mos_vth_local_z/sqrt(apm__match_size)
parameters apm__drive_intent=(1+0.029999999999999999*apm_bench_apm350_p_drive_global_z)*(1+0.025000000000000001*apm__mos_drive_local_z/sqrt(apm__match_size))-1
parameters apm__vth_raw=2*apm__vth_intent/(apm__vth_adapter_a-sqrt(apm__vth_adapter_a*apm__vth_adapter_a+4*apm__vth_adapter_b*apm__vth_intent))
parameters apm__drive_raw=1+2*apm__drive_intent/(apm__drive_adapter_a+sqrt(apm__drive_adapter_a*apm__drive_adapter_a+4*apm__drive_adapter_b*apm__drive_intent))
Mapm__core (d g s b) apm350_pcore w=w l=l ad=w*400n as=w*400n pd=2*w+800n ps=2*w+800n delvto=apm__vth_raw mulu0=apm__drive_raw
ends apm350_general_pmos
