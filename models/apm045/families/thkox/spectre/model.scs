// SPDX-FileCopyrightText: APM contributors
// SPDX-License-Identifier: Apache-2.0
//
// APM v2 model-only Spectre binding for apm045/thkox
// EXPERIMENTAL / UNVERIFIED
// Generated by tools/generate_spectre_v2.py.
// Static structure only: not parsed or simulated by Cadence Spectre.
// Include variation/spectre/benchmark_variation.scs with one section.

simulator lang=spice
.include "../../../vendor/freepdk45/NMOS_THKOX.inc"
.include "../../../vendor/freepdk45/PMOS_THKOX.inc"
simulator lang=spectre

subckt apm045_thkox_nmos (d g s b)
parameters w=9.9999999999999995e-07 l=4.9999999999999998e-08
parameters apm__match_size=(w*l)/(9.9999999999999995e-07*9.9999999999999995e-08)
parameters apm__vth_adapter_a=1.024978484243213 apm__vth_adapter_b=0.00502715366561846
parameters apm__drive_adapter_a=0.95306317844485 apm__drive_adapter_b=-0.048593668305052802
parameters apm__vth_intent=0.012*apm_bench_apm045_n_vth_global_z+0.0080000000000000002*apm__mos_vth_local_z/sqrt(apm__match_size)
parameters apm__drive_intent=(1+0.029999999999999999*apm_bench_apm045_n_drive_global_z)*(1+0.025000000000000001*apm__mos_drive_local_z/sqrt(apm__match_size))-1
parameters apm__vth_raw=2*apm__vth_intent/(apm__vth_adapter_a+sqrt(apm__vth_adapter_a*apm__vth_adapter_a+4*apm__vth_adapter_b*apm__vth_intent))
parameters apm__drive_raw=1+2*apm__drive_intent/(apm__drive_adapter_a+sqrt(apm__drive_adapter_a*apm__drive_adapter_a+4*apm__drive_adapter_b*apm__drive_intent))
Mapm__core (d g s b) NMOS_THKOX w=w l=l delvto=apm__vth_raw mulu0=apm__drive_raw
ends apm045_thkox_nmos

subckt apm045_thkox_pmos (d g s b)
parameters w=9.9999999999999995e-07 l=4.9999999999999998e-08
parameters apm__match_size=(w*l)/(9.9999999999999995e-07*9.9999999999999995e-08)
parameters apm__vth_adapter_a=-1.032915958042397 apm__vth_adapter_b=0.00192885403617263
parameters apm__drive_adapter_a=1.0127977806649819 apm__drive_adapter_b=0.00188672996128464
parameters apm__vth_intent=0.012*apm_bench_apm045_p_vth_global_z+0.0080000000000000002*apm__mos_vth_local_z/sqrt(apm__match_size)
parameters apm__drive_intent=(1+0.029999999999999999*apm_bench_apm045_p_drive_global_z)*(1+0.025000000000000001*apm__mos_drive_local_z/sqrt(apm__match_size))-1
parameters apm__vth_raw=2*apm__vth_intent/(apm__vth_adapter_a-sqrt(apm__vth_adapter_a*apm__vth_adapter_a+4*apm__vth_adapter_b*apm__vth_intent))
parameters apm__drive_raw=1+2*apm__drive_intent/(apm__drive_adapter_a+sqrt(apm__drive_adapter_a*apm__drive_adapter_a+4*apm__drive_adapter_b*apm__drive_intent))
Mapm__core (d g s b) PMOS_THKOX w=w l=l delvto=apm__vth_raw mulu0=apm__drive_raw
ends apm045_thkox_pmos
