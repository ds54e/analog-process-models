// SPDX-FileCopyrightText: APM contributors
// SPDX-License-Identifier: Apache-2.0
//
// APM v2 model-only Spectre binding for apm022/hvt
// EXPERIMENTAL / UNVERIFIED
// Generated by tools/generate_spectre_v2.py.
// Static structure only: not parsed or simulated by Cadence Spectre.
// Include variation/spectre/benchmark_variation.scs with one section.

simulator lang=spice
.include "../../../ngspice/apm022_multivt_models.inc"
simulator lang=spectre

subckt apm022_hvt_nmos (d g s b)
parameters w=9.9999999999999995e-07 l=2.4999999999999999e-08
parameters apm__match_size=(w*l)/(9.9999999999999995e-07*4.9999999999999998e-08)
parameters apm__vth_adapter_a=1 apm__vth_adapter_b=0
parameters apm__drive_adapter_a=0.51221817434268502 apm__drive_adapter_b=-0.26057111169862002
parameters apm__vth_intent=0.012*apm_bench_apm022_n_vth_global_z+0.0080000000000000002*apm__mos_vth_local_z/sqrt(apm__match_size)
parameters apm__drive_intent=(1+0.029999999999999999*apm_bench_apm022_n_drive_global_z)*(1+0.025000000000000001*apm__mos_drive_local_z/sqrt(apm__match_size))-1
parameters apm__vth_raw=apm__vth_intent/apm__vth_adapter_a
parameters apm__drive_raw=1+2*apm__drive_intent/(apm__drive_adapter_a+sqrt(apm__drive_adapter_a*apm__drive_adapter_a+4*apm__drive_adapter_b*apm__drive_intent))
Mapm__core (d g s b) apm022_hvt_ncore w=w l=l delvto=apm__vth_raw mulu0=apm__drive_raw
ends apm022_hvt_nmos

subckt apm022_hvt_pmos (d g s b)
parameters w=9.9999999999999995e-07 l=2.4999999999999999e-08
parameters apm__match_size=(w*l)/(9.9999999999999995e-07*4.9999999999999998e-08)
parameters apm__vth_adapter_a=-1 apm__vth_adapter_b=0
parameters apm__drive_adapter_a=0.62784390614197605 apm__drive_adapter_b=-0.25083632045852999
parameters apm__vth_intent=0.012*apm_bench_apm022_p_vth_global_z+0.0080000000000000002*apm__mos_vth_local_z/sqrt(apm__match_size)
parameters apm__drive_intent=(1+0.029999999999999999*apm_bench_apm022_p_drive_global_z)*(1+0.025000000000000001*apm__mos_drive_local_z/sqrt(apm__match_size))-1
parameters apm__vth_raw=apm__vth_intent/apm__vth_adapter_a
parameters apm__drive_raw=1+2*apm__drive_intent/(apm__drive_adapter_a+sqrt(apm__drive_adapter_a*apm__drive_adapter_a+4*apm__drive_adapter_b*apm__drive_intent))
Mapm__core (d g s b) apm022_hvt_pcore w=w l=l delvto=apm__vth_raw mulu0=apm__drive_raw
ends apm022_hvt_pmos
