// SPDX-FileCopyrightText: APM contributors
// SPDX-License-Identifier: Apache-2.0
//
// APM Spectre model-only compatibility
// EXPERIMENTAL / UNVERIFIED
//
// Static structural checks only; no Spectre parse or numerical validation.
// Native Spectre BSIM-CMG is used; release/version support must be confirmed
// locally with `spectre -h bsimcmg` before use.
// Include variation/spectre/benchmark_variation.scs with exactly one section.

simulator lang=spectre

model apm016f_cmg_n bsimcmg type=n bulkmod=1 geomod=1 shmod=0 \
  l=16n tfin=8n fpitch=48n hfin=32n eot=1n \
  nbody=1.5e24 nsd=1.0e26 ngate=0 \
  phig=4.45 u0=0.030 vsat=1.00e5 \
  cdsc=7.0e-3 cdscd=7.0e-3 dvt0=0.050 dvt1=0.60 \
  eta0=0.20 dsub=1.06 pclm=0.050 pdibl1=1.30 pdibl2=2.0e-4 \
  rdsmod=0 rdsw=100 cvmod=0 cgeomod=0 \
  igcmod=0 igbmod=0 gidlmod=0 iimod=0 tnom=27

model apm016f_cmg_p bsimcmg type=p bulkmod=1 geomod=1 shmod=0 \
  l=16n tfin=8n fpitch=48n hfin=32n eot=1n \
  nbody=1.5e24 nsd=1.0e26 ngate=0 \
  phig=4.75 u0=0.014 vsat=8.00e4 \
  cdsc=7.0e-3 cdscd=7.0e-3 dvt0=0.050 dvt1=0.60 \
  eta0=0.20 dsub=1.06 pclm=0.050 pdibl1=1.30 pdibl2=2.0e-4 \
  rdsmod=0 rdsw=100 cvmod=0 cgeomod=0 \
  igcmod=0 igbmod=0 gidlmod=0 iimod=0 tnom=27

subckt apm016f_nfet (d g s b)
parameters l=16n nfin=1
parameters apm__match_size=(nfin*l)/(1*32n)
parameters apm__vth_a=-1.0 apm__vth_b=0.0
parameters apm__drive_a=0.999999924138477 apm__drive_b=0.0
parameters apm__vth_intent=0.012*apm_bench_n_vth_process_z+0.008*apm__mos_vth_local_z/sqrt(apm__match_size)
parameters apm__drive_intent=(1+0.04*apm_bench_n_drive_process_z)*(1+0.025*apm__mos_drive_local_z/sqrt(apm__match_size))-1
parameters apm__vth_raw=apm__vth_intent/apm__vth_a
parameters apm__drive_raw=1+apm__drive_intent/apm__drive_a
Mapm016f_core (d g s b) apm016f_cmg_n l=l nfin=nfin delvtrand=apm__vth_raw ids0mult=apm__drive_raw
ends apm016f_nfet

subckt apm016f_pfet (d g s b)
parameters l=16n nfin=1
parameters apm__match_size=(nfin*l)/(1*32n)
parameters apm__vth_a=-1.0 apm__vth_b=0.0
parameters apm__drive_a=0.99999987839775 apm__drive_b=0.0
parameters apm__vth_intent=0.012*apm_bench_p_vth_process_z+0.008*apm__mos_vth_local_z/sqrt(apm__match_size)
parameters apm__drive_intent=(1+0.04*apm_bench_p_drive_process_z)*(1+0.025*apm__mos_drive_local_z/sqrt(apm__match_size))-1
parameters apm__vth_raw=apm__vth_intent/apm__vth_a
parameters apm__drive_raw=1+apm__drive_intent/apm__drive_a
Mapm016f_core (d g s b) apm016f_cmg_p l=l nfin=nfin delvtrand=apm__vth_raw ids0mult=apm__drive_raw
ends apm016f_pfet
