// SPDX-FileCopyrightText: APM contributors
// SPDX-License-Identifier: Apache-2.0
//
// APM v2 model-only Spectre binding for apm016f/hvt
// EXPERIMENTAL / UNVERIFIED
// Generated by tools/generate_spectre_v2.py.
// Static structure only: not parsed or simulated by Cadence Spectre.
// Include variation/spectre/benchmark_variation.scs with one section.

simulator lang=spectre
include "../../../spectre/apm016f_multivt.scs"

subckt apm016f_hvt_nfet (d g s b)
parameters l=1.6000000000000001e-08 nfin=1
parameters apm__match_size=(nfin*l)/(1*3.2000000000000002e-08)
parameters apm__vth_adapter_a=-1 apm__vth_adapter_b=0
parameters apm__drive_adapter_a=0.99999999992414301 apm__drive_adapter_b=0
parameters apm__vth_intent=0.012*apm_bench_apm016f_n_vth_global_z+0.0080000000000000002*apm__mos_vth_local_z/sqrt(apm__match_size)
parameters apm__drive_intent=(1+0.029999999999999999*apm_bench_apm016f_n_drive_global_z)*(1+0.025000000000000001*apm__mos_drive_local_z/sqrt(apm__match_size))-1
parameters apm__vth_raw=apm__vth_intent/apm__vth_adapter_a
parameters apm__drive_raw=1+apm__drive_intent/apm__drive_adapter_a
Napm__core (d g s b) apm016f_hvt_ncore l=l nfin=nfin delvtrand=apm__vth_raw ids0mult=apm__drive_raw
ends apm016f_hvt_nfet

subckt apm016f_hvt_pfet (d g s b)
parameters l=1.6000000000000001e-08 nfin=1
parameters apm__match_size=(nfin*l)/(1*3.2000000000000002e-08)
parameters apm__vth_adapter_a=-1 apm__vth_adapter_b=0
parameters apm__drive_adapter_a=0.99999999987840005 apm__drive_adapter_b=0
parameters apm__vth_intent=0.012*apm_bench_apm016f_p_vth_global_z+0.0080000000000000002*apm__mos_vth_local_z/sqrt(apm__match_size)
parameters apm__drive_intent=(1+0.029999999999999999*apm_bench_apm016f_p_drive_global_z)*(1+0.025000000000000001*apm__mos_drive_local_z/sqrt(apm__match_size))-1
parameters apm__vth_raw=apm__vth_intent/apm__vth_adapter_a
parameters apm__drive_raw=1+apm__drive_intent/apm__drive_adapter_a
Napm__core (d g s b) apm016f_hvt_pcore l=l nfin=nfin delvtrand=apm__vth_raw ids0mult=apm__drive_raw
ends apm016f_hvt_pfet
