// SPDX-FileCopyrightText: APM contributors
// SPDX-License-Identifier: Apache-2.0
// APM v2 model-only Spectre benchmark variation
// EXPERIMENTAL / UNVERIFIED
// Not parsed or simulated by Cadence Spectre.
// Benchmark Global = Spectre montecarlo variations=process.
// Benchmark Local = Spectre montecarlo variations=mismatch.
// Benchmark All = Spectre montecarlo variations=all.
// Spectre owns its random samples; seed identity with ngspice is not required.

simulator lang=spectre

library apm_benchmark_variation_v2

section bench_mc
parameters apm_bench_apm016f_n_vth_global_z=0
parameters apm_bench_apm016f_n_drive_global_z=0
parameters apm_bench_apm016f_p_vth_global_z=0
parameters apm_bench_apm016f_p_drive_global_z=0
parameters apm_bench_apm022_n_vth_global_z=0
parameters apm_bench_apm022_n_drive_global_z=0
parameters apm_bench_apm022_p_vth_global_z=0
parameters apm_bench_apm022_p_drive_global_z=0
parameters apm_bench_apm045_n_vth_global_z=0
parameters apm_bench_apm045_n_drive_global_z=0
parameters apm_bench_apm045_p_vth_global_z=0
parameters apm_bench_apm045_p_drive_global_z=0
parameters apm_bench_apm130_n_vth_global_z=0
parameters apm_bench_apm130_n_drive_global_z=0
parameters apm_bench_apm130_p_vth_global_z=0
parameters apm_bench_apm130_p_drive_global_z=0
parameters apm_bench_apm350_n_vth_global_z=0
parameters apm_bench_apm350_n_drive_global_z=0
parameters apm_bench_apm350_p_vth_global_z=0
parameters apm_bench_apm350_p_drive_global_z=0
parameters apm_bench_r_global_z=0
parameters apm_bench_c_global_z=0
parameters apm__mos_vth_local_z=0
parameters apm__mos_drive_local_z=0
parameters apm__r_local_z=0
parameters apm__c_local_z=0

statistics {
  process {
    vary apm_bench_apm016f_n_vth_global_z dist=gauss std=1 percent=no
    vary apm_bench_apm016f_n_drive_global_z dist=gauss std=1 percent=no
    vary apm_bench_apm016f_p_vth_global_z dist=gauss std=1 percent=no
    vary apm_bench_apm016f_p_drive_global_z dist=gauss std=1 percent=no
    vary apm_bench_apm022_n_vth_global_z dist=gauss std=1 percent=no
    vary apm_bench_apm022_n_drive_global_z dist=gauss std=1 percent=no
    vary apm_bench_apm022_p_vth_global_z dist=gauss std=1 percent=no
    vary apm_bench_apm022_p_drive_global_z dist=gauss std=1 percent=no
    vary apm_bench_apm045_n_vth_global_z dist=gauss std=1 percent=no
    vary apm_bench_apm045_n_drive_global_z dist=gauss std=1 percent=no
    vary apm_bench_apm045_p_vth_global_z dist=gauss std=1 percent=no
    vary apm_bench_apm045_p_drive_global_z dist=gauss std=1 percent=no
    vary apm_bench_apm130_n_vth_global_z dist=gauss std=1 percent=no
    vary apm_bench_apm130_n_drive_global_z dist=gauss std=1 percent=no
    vary apm_bench_apm130_p_vth_global_z dist=gauss std=1 percent=no
    vary apm_bench_apm130_p_drive_global_z dist=gauss std=1 percent=no
    vary apm_bench_apm350_n_vth_global_z dist=gauss std=1 percent=no
    vary apm_bench_apm350_n_drive_global_z dist=gauss std=1 percent=no
    vary apm_bench_apm350_p_vth_global_z dist=gauss std=1 percent=no
    vary apm_bench_apm350_p_drive_global_z dist=gauss std=1 percent=no
    vary apm_bench_r_global_z dist=gauss std=1 percent=no
    vary apm_bench_c_global_z dist=gauss std=1 percent=no
  }
  mismatch {
    vary apm__mos_vth_local_z dist=gauss std=1 percent=no
    vary apm__mos_drive_local_z dist=gauss std=1 percent=no
    vary apm__r_local_z dist=gauss std=1 percent=no
    vary apm__c_local_z dist=gauss std=1 percent=no
  }
}
endsection bench_mc

section bench_tt
parameters apm_bench_apm016f_n_vth_global_z=0
parameters apm_bench_apm016f_n_drive_global_z=0
parameters apm_bench_apm016f_p_vth_global_z=0
parameters apm_bench_apm016f_p_drive_global_z=0
parameters apm_bench_apm022_n_vth_global_z=0
parameters apm_bench_apm022_n_drive_global_z=0
parameters apm_bench_apm022_p_vth_global_z=0
parameters apm_bench_apm022_p_drive_global_z=0
parameters apm_bench_apm045_n_vth_global_z=0
parameters apm_bench_apm045_n_drive_global_z=0
parameters apm_bench_apm045_p_vth_global_z=0
parameters apm_bench_apm045_p_drive_global_z=0
parameters apm_bench_apm130_n_vth_global_z=0
parameters apm_bench_apm130_n_drive_global_z=0
parameters apm_bench_apm130_p_vth_global_z=0
parameters apm_bench_apm130_p_drive_global_z=0
parameters apm_bench_apm350_n_vth_global_z=0
parameters apm_bench_apm350_n_drive_global_z=0
parameters apm_bench_apm350_p_vth_global_z=0
parameters apm_bench_apm350_p_drive_global_z=0
parameters apm_bench_r_global_z=0
parameters apm_bench_c_global_z=0
parameters apm__mos_vth_local_z=0
parameters apm__mos_drive_local_z=0
parameters apm__r_local_z=0
parameters apm__c_local_z=0
endsection bench_tt

section bench_ff
parameters apm_bench_apm016f_n_vth_global_z=-3
parameters apm_bench_apm016f_n_drive_global_z=3
parameters apm_bench_apm016f_p_vth_global_z=-3
parameters apm_bench_apm016f_p_drive_global_z=3
parameters apm_bench_apm022_n_vth_global_z=-3
parameters apm_bench_apm022_n_drive_global_z=3
parameters apm_bench_apm022_p_vth_global_z=-3
parameters apm_bench_apm022_p_drive_global_z=3
parameters apm_bench_apm045_n_vth_global_z=-3
parameters apm_bench_apm045_n_drive_global_z=3
parameters apm_bench_apm045_p_vth_global_z=-3
parameters apm_bench_apm045_p_drive_global_z=3
parameters apm_bench_apm130_n_vth_global_z=-3
parameters apm_bench_apm130_n_drive_global_z=3
parameters apm_bench_apm130_p_vth_global_z=-3
parameters apm_bench_apm130_p_drive_global_z=3
parameters apm_bench_apm350_n_vth_global_z=-3
parameters apm_bench_apm350_n_drive_global_z=3
parameters apm_bench_apm350_p_vth_global_z=-3
parameters apm_bench_apm350_p_drive_global_z=3
parameters apm_bench_r_global_z=0
parameters apm_bench_c_global_z=0
parameters apm__mos_vth_local_z=0
parameters apm__mos_drive_local_z=0
parameters apm__r_local_z=0
parameters apm__c_local_z=0
endsection bench_ff

section bench_ss
parameters apm_bench_apm016f_n_vth_global_z=3
parameters apm_bench_apm016f_n_drive_global_z=-3
parameters apm_bench_apm016f_p_vth_global_z=3
parameters apm_bench_apm016f_p_drive_global_z=-3
parameters apm_bench_apm022_n_vth_global_z=3
parameters apm_bench_apm022_n_drive_global_z=-3
parameters apm_bench_apm022_p_vth_global_z=3
parameters apm_bench_apm022_p_drive_global_z=-3
parameters apm_bench_apm045_n_vth_global_z=3
parameters apm_bench_apm045_n_drive_global_z=-3
parameters apm_bench_apm045_p_vth_global_z=3
parameters apm_bench_apm045_p_drive_global_z=-3
parameters apm_bench_apm130_n_vth_global_z=3
parameters apm_bench_apm130_n_drive_global_z=-3
parameters apm_bench_apm130_p_vth_global_z=3
parameters apm_bench_apm130_p_drive_global_z=-3
parameters apm_bench_apm350_n_vth_global_z=3
parameters apm_bench_apm350_n_drive_global_z=-3
parameters apm_bench_apm350_p_vth_global_z=3
parameters apm_bench_apm350_p_drive_global_z=-3
parameters apm_bench_r_global_z=0
parameters apm_bench_c_global_z=0
parameters apm__mos_vth_local_z=0
parameters apm__mos_drive_local_z=0
parameters apm__r_local_z=0
parameters apm__c_local_z=0
endsection bench_ss

section bench_fs
parameters apm_bench_apm016f_n_vth_global_z=-3
parameters apm_bench_apm016f_n_drive_global_z=3
parameters apm_bench_apm016f_p_vth_global_z=3
parameters apm_bench_apm016f_p_drive_global_z=-3
parameters apm_bench_apm022_n_vth_global_z=-3
parameters apm_bench_apm022_n_drive_global_z=3
parameters apm_bench_apm022_p_vth_global_z=3
parameters apm_bench_apm022_p_drive_global_z=-3
parameters apm_bench_apm045_n_vth_global_z=-3
parameters apm_bench_apm045_n_drive_global_z=3
parameters apm_bench_apm045_p_vth_global_z=3
parameters apm_bench_apm045_p_drive_global_z=-3
parameters apm_bench_apm130_n_vth_global_z=-3
parameters apm_bench_apm130_n_drive_global_z=3
parameters apm_bench_apm130_p_vth_global_z=3
parameters apm_bench_apm130_p_drive_global_z=-3
parameters apm_bench_apm350_n_vth_global_z=-3
parameters apm_bench_apm350_n_drive_global_z=3
parameters apm_bench_apm350_p_vth_global_z=3
parameters apm_bench_apm350_p_drive_global_z=-3
parameters apm_bench_r_global_z=0
parameters apm_bench_c_global_z=0
parameters apm__mos_vth_local_z=0
parameters apm__mos_drive_local_z=0
parameters apm__r_local_z=0
parameters apm__c_local_z=0
endsection bench_fs

section bench_sf
parameters apm_bench_apm016f_n_vth_global_z=3
parameters apm_bench_apm016f_n_drive_global_z=-3
parameters apm_bench_apm016f_p_vth_global_z=-3
parameters apm_bench_apm016f_p_drive_global_z=3
parameters apm_bench_apm022_n_vth_global_z=3
parameters apm_bench_apm022_n_drive_global_z=-3
parameters apm_bench_apm022_p_vth_global_z=-3
parameters apm_bench_apm022_p_drive_global_z=3
parameters apm_bench_apm045_n_vth_global_z=3
parameters apm_bench_apm045_n_drive_global_z=-3
parameters apm_bench_apm045_p_vth_global_z=-3
parameters apm_bench_apm045_p_drive_global_z=3
parameters apm_bench_apm130_n_vth_global_z=3
parameters apm_bench_apm130_n_drive_global_z=-3
parameters apm_bench_apm130_p_vth_global_z=-3
parameters apm_bench_apm130_p_drive_global_z=3
parameters apm_bench_apm350_n_vth_global_z=3
parameters apm_bench_apm350_n_drive_global_z=-3
parameters apm_bench_apm350_p_vth_global_z=-3
parameters apm_bench_apm350_p_drive_global_z=3
parameters apm_bench_r_global_z=0
parameters apm_bench_c_global_z=0
parameters apm__mos_vth_local_z=0
parameters apm__mos_drive_local_z=0
parameters apm__r_local_z=0
parameters apm__c_local_z=0
endsection bench_sf

endlibrary apm_benchmark_variation_v2
